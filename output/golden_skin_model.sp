* Equivalent circuit model for output\golden_skin_model.sp
.SUBCKT golden_skin_model po1
Vsp1 po1 p1 0
Vsr1 p1 pr1 0
Rp1 pr1 0 50
Ru1 u1 0 50
Fr1 u1 0 Vsr1 -1
Fu1 u1 0 Vsp1 -1
Ry1 y1 0 1
Gy1 p1 0 y1 0 -0.02
Rx1 x1 0 1
Fxc1_2 x1 0 Vx2 0.712827757320504
Cx1 x1 xm1 1.86054485033744e-12
Vx1 xm1 0 0
Gx1_1 x1 0 u1 0 -0.663070543715889
Rx2 x2 0 1
Fxc2_1 x2 0 Vx1 -0.836039951948059
Cx2 x2 xm2 1.86054485033744e-12
Vx2 xm2 0 0
Gx2_1 x2 0 u1 0 0.554353465506405
Rx3 x3 0 1
Fxc3_4 x3 0 Vx4 531.248929019456
Cx3 x3 xm3 4.31166141565346e-13
Vx3 xm3 0 0
Gx3_1 x3 0 u1 0 -1.15650502550369e-06
Rx4 x4 0 1
Fxc4_3 x4 0 Vx3 -3.14575951124748
Cx4 x4 xm4 4.31166141565346e-13
Vx4 xm4 0 0
Gx4_1 x4 0 u1 0 3.63808668378374e-06
Rx5 x5 0 1
Fxc5_6 x5 0 Vx6 427.964231816647
Cx5 x5 xm5 2.44971600693759e-14
Vx5 xm5 0 0
Gx5_1 x5 0 u1 0 -1.94323937259562e-08
Rx6 x6 0 1
Fxc6_5 x6 0 Vx5 -1706.76630787535
Cx6 x6 xm6 2.44971600693759e-14
Vx6 xm6 0 0
Gx6_1 x6 0 u1 0 3.31665548928304e-05
Rx7 x7 0 1
Fxc7_8 x7 0 Vx8 61.2045580733524
Cx7 x7 xm7 3.28980099319052e-13
Vx7 xm7 0 0
Gx7_1 x7 0 u1 0 -5.22155967672347e-07
Rx8 x8 0 1
Fxc8_7 x8 0 Vx7 -83.4501669433957
Cx8 x8 xm8 3.28980099319052e-13
Vx8 xm8 0 0
Gx8_1 x8 0 u1 0 4.35740026727477e-05
Rx9 x9 0 1
Fxc9_10 x9 0 Vx10 7949.86922005476
Cx9 x9 xm9 2.19451412954742e-15
Vx9 xm9 0 0
Gx9_1 x9 0 u1 0 -1.21075859124155e-09
Rx10 x10 0 1
Fxc10_9 x10 0 Vx9 -24401.3483213923
Cx10 x10 xm10 2.19451412954742e-15
Vx10 xm10 0 0
Gx10_1 x10 0 u1 0 2.95441421180033e-05
Rx11 x11 0 1
Fxc11_12 x11 0 Vx12 2.15860343282593
Cx11 x11 xm11 1.10280812528525e-11
Vx11 xm11 0 0
Gx11_1 x11 0 u1 0 -0.000137788038177072
Rx12 x12 0 1
Fxc12_11 x12 0 Vx11 -8.34125560863327
Cx12 x12 xm12 1.10280812528525e-11
Vx12 xm12 0 0
Gx12_1 x12 0 u1 0 0.00114932524624708
Rx13 x13 0 1
Fxc13_14 x13 0 Vx14 34.1213515680702
Cx13 x13 xm13 4.9805267405142e-12
Vx13 xm13 0 0
Gx13_1 x13 0 u1 0 -5.01714702483071e-05
Rx14 x14 0 1
Fxc14_13 x14 0 Vx13 -4.75343497007401
Cx14 x14 xm14 4.9805267405142e-12
Vx14 xm14 0 0
Gx14_1 x14 0 u1 0 0.000238486821178331
Rx15 x15 0 1
Fxc15_16 x15 0 Vx16 0.0886018706902178
Cx15 x15 xm15 1.27260045502068e-10
Vx15 xm15 0 0
Gx15_1 x15 0 u1 0 -0.00251794130338548
Rx16 x16 0 1
Fxc16_15 x16 0 Vx15 -4.31479144322813
Cx16 x16 xm16 1.27260045502068e-10
Vx16 xm16 0 0
Gx16_1 x16 0 u1 0 0.0108643915903983
Rx17 x17 0 1
Cx17 x17 0 9.07087868358318e-10
Gx17_1 x17 0 u1 0 -0.400710303732779
Rx18 x18 0 1
Cx18 x18 0 4.80269826176629e-09
Gx18_1 x18 0 u1 0 -0.500889152566846
Gyc1_1 y1 0 x1 0 -1
Gyc1_2 y1 0 x2 0 -1
Gyc1_3 y1 0 x3 0 1
Gyc1_4 y1 0 x4 0 -1
Gyc1_5 y1 0 x5 0 1
Gyc1_6 y1 0 x6 0 -1
Gyc1_7 y1 0 x7 0 -1
Gyc1_8 y1 0 x8 0 -1
Gyc1_9 y1 0 x9 0 -1
Gyc1_10 y1 0 x10 0 -1
Gyc1_11 y1 0 x11 0 1
Gyc1_12 y1 0 x12 0 -1
Gyc1_13 y1 0 x13 0 -1
Gyc1_14 y1 0 x14 0 -1
Gyc1_15 y1 0 x15 0 1
Gyc1_16 y1 0 x16 0 -1
Gyc1_17 y1 0 x17 0 1
Gyc1_18 y1 0 x18 0 1
.ENDS
